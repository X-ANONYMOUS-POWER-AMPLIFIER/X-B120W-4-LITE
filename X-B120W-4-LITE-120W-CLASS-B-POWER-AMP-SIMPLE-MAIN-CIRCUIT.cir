.title KiCad schematic
.include "/home/opensuse/Documents/ELECTRONICS-ENGINEERING/CUSTOM-DESIGN/X-AUDIO/X-B120W-4-LITE-120W-CLASS-B-POWER-AMP-SIMPLE-MAIN-CIRCUIT-V2/SPICE-MODELS/1N4007.LIB"
.include "/home/opensuse/Documents/ELECTRONICS-ENGINEERING/CUSTOM-DESIGN/X-AUDIO/X-B120W-4-LITE-120W-CLASS-B-POWER-AMP-SIMPLE-MAIN-CIRCUIT-V2/SPICE-MODELS/1N4148.LIB"
.include "/home/opensuse/Documents/ELECTRONICS-ENGINEERING/CUSTOM-DESIGN/X-AUDIO/X-B120W-4-LITE-120W-CLASS-B-POWER-AMP-SIMPLE-MAIN-CIRCUIT-V2/SPICE-MODELS/2N5401.LIB"
.include "/home/opensuse/Documents/ELECTRONICS-ENGINEERING/CUSTOM-DESIGN/X-AUDIO/X-B120W-4-LITE-120W-CLASS-B-POWER-AMP-SIMPLE-MAIN-CIRCUIT-V2/SPICE-MODELS/2N5551.LIB"
.include "/home/opensuse/Documents/ELECTRONICS-ENGINEERING/CUSTOM-DESIGN/X-AUDIO/X-B120W-4-LITE-120W-CLASS-B-POWER-AMP-SIMPLE-MAIN-CIRCUIT-V2/SPICE-MODELS/2SA1943.LIB"
.include "/home/opensuse/Documents/ELECTRONICS-ENGINEERING/CUSTOM-DESIGN/X-AUDIO/X-B120W-4-LITE-120W-CLASS-B-POWER-AMP-SIMPLE-MAIN-CIRCUIT-V2/SPICE-MODELS/2SC5200.LIB"
.include "/home/opensuse/Documents/ELECTRONICS-ENGINEERING/CUSTOM-DESIGN/X-AUDIO/X-B120W-4-LITE-120W-CLASS-B-POWER-AMP-SIMPLE-MAIN-CIRCUIT-V2/SPICE-MODELS/POTENTIOMETER.LIB"
.include "/home/opensuse/Documents/ELECTRONICS-ENGINEERING/CUSTOM-DESIGN/X-AUDIO/X-B120W-4-LITE-120W-CLASS-B-POWER-AMP-SIMPLE-MAIN-CIRCUIT-V2/SPICE-MODELS/TIP41C.LIB"
.include "/home/opensuse/Documents/ELECTRONICS-ENGINEERING/CUSTOM-DESIGN/X-AUDIO/X-B120W-4-LITE-120W-CLASS-B-POWER-AMP-SIMPLE-MAIN-CIRCUIT-V2/SPICE-MODELS/TIP42C.LIB"
.title SIMPLE 120W CLASS-B POWER AMPLIFIER MAIN-CIRCUIT FOR 4-OHMS OUTPUT LOAD
.options abstol=1u
.control
set specwindow=flattop
.endc
.PARAM BIAS=0.333
.PARAM OFFSET=0.333
.PARAM R_LOAD=4
R4026 OUTPUT PW_OUT 2.2
L4001 PW_OUT OUTPUT 1u
D4007 -42V PW_OUT 1N4007
D4006 PW_OUT +42V 1N4007
R4025 PW_OUT Net-_C4011-Pad1_ 15
C4011 Net-_C4011-Pad1_ 0 0.1u
R4011 Net-_Q4006-E_ -42V 560
Q4007 Net-_Q4007-C_ Net-_Q4006-E_ -42V 2N5551
C4007 Net-_C4007-Pad1_ Net-_Q4008-E_ 33u
R4013 Net-_Q4008-E_ -42V 560
Q4011 +42V Net-_Q4009-C_ Net-_Q4011-E_ Qtip41c
Q4013 +42V Net-_Q4013-B_ Net-_CNT4006-Pin_1_ 2SC5200
R4021 Net-_CNT4006-Pin_1_ PW_OUT 0.12
R4020 Net-_Q4011-E_ Net-_Q4013-B_ 0.82
R4018 Net-_Q4011-E_ PW_OUT 220
R4014 +42V Net-_D4005-A_ 680
R4015 +42V Net-_Q4009-E_ 100
RWJ4011 Net-_Q4010-B_ Net-_WJ4009-Pad1_ 0.001
R4016 Net-_Q4009-C_ Net-_Q4010-B_ 680
Q4009 Net-_Q4009-C_ Net-_D4005-K_ Net-_Q4009-E_ 2N5401
D4005 Net-_D4005-A_ Net-_D4005-K_ 1N4148
C4008 Net-_Q4009-C_ Net-_D4005-K_ 22p
RNTC4001 Net-_RNTC4001-Pad1_ Net-_RNTC4001-Pad2_ 2k
RWJ4009 Net-_WJ4009-Pad1_ Net-_RNTC4001-Pad2_ 0.001
C4009 +42V Net-_Q4009-E_ 100u
RWJ4010 Net-_Q4009-C_ Net-_WJ4008-Pad1_ 0.001
RWJ4008 Net-_WJ4008-Pad1_ Net-_RNTC4001-Pad1_ 0.001
RWJ4003 Net-_Q4010-E_ Net-_Q4007-C_ 0.001
Q4010 Net-_Q4009-C_ Net-_Q4010-B_ Net-_Q4010-E_ 2N5551
C4010 Net-_Q4009-C_ Net-_Q4010-E_ 0.1u
XRT4002 Net-_R4017-Pad2_ Net-_Q4010-E_ rpot_2_p value=100 pos={BIAS}
RWJ4007 Net-_Q4008-C_ Net-_D4005-K_ 0.001
R4012 0 Net-_D4003-A_ 15k
Q4008 Net-_Q4008-C_ Net-_D4003-A_ Net-_Q4008-E_ 2N5551
R4017 Net-_Q4010-B_ Net-_R4017-Pad2_ 180
R4019 PW_OUT Net-_Q4012-E_ 220
R4023 PW_OUT Net-_Q4014-E_ 0.12
Q4014 -42V Net-_Q4014-B_ Net-_Q4014-E_ 2SA1943
R4022 Net-_Q4014-B_ Net-_Q4012-E_ 0.82
Q4012 -42V Net-_Q4007-C_ Net-_Q4012-E_ Qtip42c
RWJ4006 Net-_C4007-Pad1_ Net-_Q4006-E_ 0.001
D4003 Net-_D4003-A_ Net-_D4003-K_ 1N4148
R4010 +42V Net-_Q4006-C_ 120
D4004 Net-_D4003-K_ -42V 1N4148
R4004 Net-_Q4001-C_ Net-_Q4002-E_ 18
R4002 Net-_D4002-K_ 0 15k
C4001 +42V 0 100u
D4001 +42V Net-_D4001-K_ 1N4148
D4002 Net-_D4001-K_ Net-_D4002-K_ 1N4148
R4008 Net-_C4003-Pad1_ INPUT 510
C4004 Net-_Q4002-B_ Net-_C4003-Pad1_ 470u
Q4002 Net-_Q4002-C_ Net-_Q4002-B_ Net-_Q4002-E_ 2N5401
C4002 0 -42V 100u
Q4004 Net-_Q4002-C_ Net-_Q4003-C_ -42V 2N5551
C4003 Net-_C4003-Pad1_ AGND 22p
R4001 0 AGND 10
R4006 Net-_Q4002-B_ AGND 15k
RLOAD1 OUTPUT 0 {R_LOAD}
V2 Net-_RX1-Pad2_ AGND dc 0 ac 1 sin(0 1.096 1K 0 0)
V1 -42V 0 DC -42V
RX1 INPUT Net-_RX1-Pad2_ 1
RG1 0 AGND 0.01
V4001 +42V 0 DC 42
Q4003 Net-_Q4003-C_ Net-_Q4003-B_ Net-_Q4003-E_ 2N5401
RWJ4002 Net-_R4007-Pad1_ PW_OUT 0.001
R4007 Net-_R4007-Pad1_ Net-_Q4003-B_ 15k
R4003 +42V Net-_Q4001-E_ 220
Q4001 Net-_Q4001-C_ Net-_D4002-K_ Net-_Q4001-E_ 2N5401
R4005 Net-_Q4001-C_ Net-_Q4003-E_ 18
XRT4001 Net-_Q4002-E_ Net-_R4024-Pad2_ Net-_Q4003-E_ rpot value=3k pos={OFFSET}
R4024 Net-_Q4001-C_ Net-_R4024-Pad2_ 470
C4005 Net-_C4005-Pad1_ AGND 470u
Q4006 Net-_Q4006-C_ Net-_Q4002-C_ Net-_Q4006-E_ 2N5551
C4006 Net-_Q4007-C_ Net-_Q4002-C_ 22p
Q4005 Net-_Q4003-C_ Net-_Q4003-C_ -42V 2N5551
R4009 Net-_Q4003-B_ Net-_C4005-Pad1_ 510
.end
